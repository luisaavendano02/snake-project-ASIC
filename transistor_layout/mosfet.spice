* NGSPICE file created from mosfet.ext - technology: sky130A

.subckt mosfet gate drain source
X0 source gate drain VSUBS sky130_fd_pr__nfet_01v8 ad=0.26 pd=2.1 as=0.26 ps=2.1 w=0.65 l=0.15
.ends
