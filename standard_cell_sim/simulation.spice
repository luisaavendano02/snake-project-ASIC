* Simulacion de celda NAND2 - sky130_fd_sc_hd__nand2_1
* Snake Project - Standard Cell Simulation

* Modelos de transistores Sky130
.lib /foss/pdks/sky130A/libs.tech/ngspice/sky130.lib.spice tt

* Incluir todas las celdas estandar
.include /foss/pdks/sky130A/libs.ref/sky130_fd_sc_hd/spice/sky130_fd_sc_hd.spice

* Instanciar la celda NAND2
* A B VGND VNB VPB VPWR Y
Xcell A B VGND VGND VPWR VPWR Y sky130_fd_sc_hd__nand2_1

* Alimentacion
Vpwr VPWR VGND 1.8

* Tierra
Vgnd VGND 0 0

* Pulsos de entrada
Va A VGND pulse(0 1.8 1n 10p 10p 1n 2n)
Vb B VGND pulse(0 1.8 1.5n 10p 10p 1n 2n)

* Analisis transitorio
.tran 10p 4n

* Graficar resultados
.control
run
plot A B Y
.endc

.end
